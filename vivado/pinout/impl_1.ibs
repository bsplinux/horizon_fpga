| / 7\'7
| \ \   Xilinx Inc.
| / /
| \_\/.\   IBIS Models for ZYNQ7 IO
[IBIS ver]   4.2
[File name]   impl_1.ibs
[File Rev]   2.8
[Date]   Mon January 01 14:28:39 2024
[Source]   Derived from spice models, rev1.0, using
   hspice 2010.03-ENG2
[Notes]   Xilinx IBIS file for ZYNQ7 I/O standards.
   All models are preliminary.
   The version of IBISCHK used is ibischk5.
   Ibis models were generated using S2IBIS3.
[Disclaimer] The data in this file is derived from SPICE simulations using
                 modeling information extracted from the target process.
                 A great deal of care has been taken to provide information
                 that is accurate. This model has been verified by actual silicon
                 measurement.
[Copyright]   Copyright 2012-2016, Xilinx Inc., All rights reserved
|   Component ZYNQ7
[Component]   ZYNQ
[Manufacturer]   Xilinx Inc.
[Package]
|CLG400
|variable   typ   min   max
R_pkg   409.3m   130.9m   730.5m
L_pkg   8.10nH   2.71nH   14.76nH
C_pkg   1.31pF   0.33pF   2.90pF
[Pin]   signal_name   model_name  R_pin  L_pin  C_pin
A1   DDR_dm[0]   SSTL15_DCI_F_PSDDR_MS
A2   DDR_dq[2]   SSTL15_DCI_F_PSDDR_MS
A3   VCCO_DDR_502   POWER
A4   DDR_dq[3]   SSTL15_DCI_F_PSDDR_MS
A5   FIXED_IO_mio[6]   LVCMOS33_S_8_PSMIO
A6   FIXED_IO_mio[5]   LVCMOS33_S_8_PSMIO
A7   FIXED_IO_mio[1]   LVCMOS33_S_8_PSMIO
A8   GND   GND
A9   FIXED_IO_mio[43]   LVCMOS18_S_8_PSMIO
A10   FIXED_IO_mio[37]   LVCMOS18_S_8_PSMIO
A11   FIXED_IO_mio[36]   LVCMOS18_S_8_PSMIO
A12   FIXED_IO_mio[34]   LVCMOS18_S_8_PSMIO
A13   VCCO_MIO1_501   POWER
A14   FIXED_IO_mio[32]   LVCMOS18_S_8_PSMIO
A15   FIXED_IO_mio[26]   LVCMOS18_S_8_PSMIO
A16   FIXED_IO_mio[24]   LVCMOS18_S_8_PSMIO
A17   FIXED_IO_mio[20]   LVCMOS18_S_8_PSMIO
A18   GND   GND
A19   FIXED_IO_mio[16]   LVCMOS18_S_8_PSMIO
A20   FAN_PG3_FPGA   LVCMOS33_S_8_HR
B1   GND   GND
B2   DDR_dqs_n[0]   SSTL15_DCI_F_PSDDR_MS
B3   DDR_dq[1]   SSTL15_DCI_F_PSDDR_MS
B4   DDR_reset_n   SSTL15_F_PSDDR
B5   FIXED_IO_mio[9]   LVCMOS33_S_8_PSMIO
B6   VCCO_MIO0_500   POWER
B7   FIXED_IO_mio[4]   LVCMOS33_S_8_PSMIO
B8   FIXED_IO_mio[2]   LVCMOS33_S_8_PSMIO
B9   FIXED_IO_mio[51]   LVCMOS18_S_8_PSMIO
B10   FIXED_IO_ps_srstb   NC
B11   GND   GND
B12   FIXED_IO_mio[48]   LVCMOS18_S_8_PSMIO
B13   FIXED_IO_mio[50]   LVCMOS18_S_8_PSMIO
B14   FIXED_IO_mio[47]   LVCMOS18_S_8_PSMIO
B15   FIXED_IO_mio[45]   LVCMOS18_S_8_PSMIO
B16   VCCO_MIO1_501   POWER
B17   FIXED_IO_mio[22]   LVCMOS18_S_8_PSMIO
B18   FIXED_IO_mio[18]   LVCMOS18_S_8_PSMIO
B19   FAN_HALL3_FPGA   LVCMOS33_S_8_HR
B20   IO_L1N_T0_AD0N_35   NC
C1   DDR_dq[6]   SSTL15_DCI_F_PSDDR_MS
C2   DDR_dqs_p[0]   SSTL15_DCI_F_PSDDR_MS
C3   DDR_dq[0]   SSTL15_DCI_F_PSDDR_MS
C4   GND   GND
C5   FIXED_IO_mio[14]   LVCMOS33_S_8_PSMIO
C6   FIXED_IO_mio[11]   LVCMOS33_S_8_PSMIO
C7   FIXED_IO_ps_porb   NC
C8   FIXED_IO_mio[15]   LVCMOS33_S_8_PSMIO
C9   GND   GND
C10   FIXED_IO_mio[52]   LVCMOS18_S_8_PSMIO
C11   FIXED_IO_mio[53]   LVCMOS18_S_8_PSMIO
C12   FIXED_IO_mio[49]   LVCMOS18_S_8_PSMIO
C13   FIXED_IO_mio[29]   LVCMOS18_S_8_PSMIO
C14   GND   GND
C15   FIXED_IO_mio[30]   LVCMOS18_S_8_PSMIO
C16   FIXED_IO_mio[28]   LVCMOS18_S_8_PSMIO
C17   FIXED_IO_mio[41]   LVCMOS18_S_8_PSMIO
C18   FIXED_IO_mio[39]   LVCMOS18_S_8_PSMIO
C19   VCCO_35   POWER
C20   IO_L1P_T0_AD0P_35   NC
D1   DDR_dq[5]   SSTL15_DCI_F_PSDDR_MS
D2   VCCO_DDR_502   POWER
D3   DDR_dq[4]   SSTL15_DCI_F_PSDDR_MS
D4   DDR_addr[13]   SSTL15_S_PSDDR
D5   FIXED_IO_mio[8]   LVCMOS33_S_8_PSMIO
D6   FIXED_IO_mio[3]   LVCMOS33_S_8_PSMIO
D7   VCCO_MIO0_500   POWER
D8   FIXED_IO_mio[7]   LVCMOS33_S_8_PSMIO
D9   FIXED_IO_mio[12]   LVCMOS33_S_8_PSMIO
D10   FIXED_IO_mio[19]   LVCMOS18_S_8_PSMIO
D11   FIXED_IO_mio[23]   LVCMOS18_S_8_PSMIO
D12   VCCO_MIO1_501   POWER
D13   FIXED_IO_mio[27]   LVCMOS18_S_8_PSMIO
D14   FIXED_IO_mio[40]   LVCMOS18_S_8_PSMIO
D15   FIXED_IO_mio[33]   LVCMOS18_S_8_PSMIO
D16   FIXED_IO_mio[46]   LVCMOS18_S_8_PSMIO
D17   GND   GND
D18   FAN_EN3_FPGA   LVCMOS33_S_12_HR
D19   FAN_HALL2_FPGA   LVCMOS33_S_8_HR
D20   FAN_PG2_FPGA   LVCMOS33_S_8_HR
E1   DDR_dq[7]   SSTL15_DCI_F_PSDDR_MS
E2   DDR_dq[8]   SSTL15_DCI_F_PSDDR_MS
E3   DDR_dq[9]   SSTL15_DCI_F_PSDDR_MS
E4   DDR_addr[12]   SSTL15_S_PSDDR
E5   VCCO_DDR_502   POWER
E6   FIXED_IO_mio[0]   LVCMOS33_S_8_PSMIO
E7   FIXED_IO_ps_clk   NC
E8   FIXED_IO_mio[13]   LVCMOS33_S_8_PSMIO
E9   FIXED_IO_mio[10]   LVCMOS33_S_8_PSMIO
E10   GND   GND
E11   PS_MIO_VREF_501   NC
E12   FIXED_IO_mio[42]   LVCMOS18_S_8_PSMIO
E13   FIXED_IO_mio[38]   LVCMOS18_S_8_PSMIO
E14   FIXED_IO_mio[17]   LVCMOS18_S_8_PSMIO
E15   VCCO_MIO1_501   POWER
E16   FIXED_IO_mio[31]   LVCMOS18_S_8_PSMIO
E17   FAN_CTRL3_FPGA   LVCMOS33_S_12_HR
E18   FAN_CTRL2_FPGA   LVCMOS33_S_12_HR
E19   FAN_EN2_FPGA   LVCMOS33_S_12_HR
E20   GND   GND
F1   DDR_dm[1]   SSTL15_DCI_F_PSDDR_MS
F2   DDR_dqs_n[1]   SSTL15_DCI_F_PSDDR_MS
F3   GND   GND
F4   DDR_addr[14]   SSTL15_S_PSDDR
F5   DDR_addr[10]   SSTL15_S_PSDDR
F6   TDO_0   LVCMOS18_F_12_HR
F7   GND   GND
F8   VCCPAUX   POWER
F9   TCK_0   LVCMOS18_F_12_HR
F10   RSVDGND   GND
F11   VCCBATT_0   LVCMOS18_F_12_HR
F12   FIXED_IO_mio[35]   LVCMOS18_S_8_PSMIO
F13   FIXED_IO_mio[44]   LVCMOS18_S_8_PSMIO
F14   FIXED_IO_mio[21]   LVCMOS18_S_8_PSMIO
F15   FIXED_IO_mio[25]   LVCMOS18_S_8_PSMIO
F16   IO_L6P_T0_35   NC
F17   IO_L6N_T0_VREF_35   NC
F18   VCCO_35   POWER
F19   IO_L15P_T2_DQS_AD12P_35   NC
F20   IO_L15N_T2_DQS_AD12N_35   NC
G1   VCCO_DDR_502   POWER
G2   DDR_dqs_p[1]   SSTL15_DCI_F_PSDDR_MS
G3   DDR_dq[10]   SSTL15_DCI_F_PSDDR_MS
G4   DDR_addr[11]   SSTL15_S_PSDDR
G5   FIXED_IO_ddr_vrn   NC
G6   TDI_0   LVCMOS18_F_12_HR
G7   VCCPINT   POWER
G8   VCCPLL   POWER
G9   VCCPAUX   POWER
G10   GND   GND
G11   VCCBRAM   POWER
G12   GND   GND
G13   VCCINT   POWER
G14   IO_0_35   NC
G15   SHUTDOWN_OUT_FPGA   LVCMOS33_S_12_HR
G16   GND   GND
G17   POD_STATUS_FPGA   LVCMOS33_S_12_HR
G18   P_IN_STATUS_FPGA   LVCMOS33_S_12_HR
G19   CCTCU_INH_FPGA   LVCMOS33_S_12_HR
G20   IO_L18N_T2_AD13N_35   NC
H1   DDR_dq[14]   SSTL15_DCI_F_PSDDR_MS
H2   DDR_dq[13]   SSTL15_DCI_F_PSDDR_MS
H3   DDR_dq[11]   SSTL15_DCI_F_PSDDR_MS
H4   VCCO_DDR_502   POWER
H5   FIXED_IO_ddr_vrp   NC
H6   PS_DDR_VREF0_502   NC
H7   GND   GND
H8   VCCPAUX   POWER
H9   GND   GND
H10   VCCBRAM   POWER
H11   GND   GND
H12   VCCINT   POWER
H13   GND   GND
H14   VCCO_35   POWER
H15   RESET_OUT_FPGA   LVCMOS33_S_12_HR
H16   PH_A_ON_fpga   LVCMOS33_S_8_HR
H17   PH_B_ON_fpga   LVCMOS33_S_8_HR
H18   IO_L14N_T2_AD4N_SRCC_35   NC
H19   GND   GND
H20   ECTCU_INH_FPGA   LVCMOS33_S_12_HR
J1   DDR_dq[15]   SSTL15_DCI_F_PSDDR_MS
J2   GND   GND
J3   DDR_dq[12]   SSTL15_DCI_F_PSDDR_MS
J4   DDR_addr[9]   SSTL15_S_PSDDR
J5   DDR_ba[2]   SSTL15_S_PSDDR
J6   TMS_0   LVCMOS18_F_12_HR
J7   VCCPINT   POWER
J8   GND   GND
J9   VCCADC_0   NC
J10   GNDADC_0   NC
J11   VCCAUX   POWER
J12   GND   GND
J13   VCCINT   POWER
J14   SPARE_OUT_FPGA   LVCMOS33_S_12_HR
J15   lamp_status_fpga   LVCMOS33_S_8_HR
J16   RELAY_1PH_FPGA   LVCMOS33_S_12_HR
J17   VCCO_35   POWER
J18   PH_C_ON_fpga   LVCMOS33_S_8_HR
J19   IO_L10N_T1_AD11N_35   NC
J20   P_OUT_STATUS_FPGA   LVCMOS33_S_12_HR
K1   DDR_addr[8]   SSTL15_S_PSDDR
K2   DDR_addr[1]   SSTL15_S_PSDDR
K3   DDR_addr[3]   SSTL15_S_PSDDR
K4   DDR_addr[7]   SSTL15_S_PSDDR
K5   GND   GND
K6   VCCO_0   POWER
K7   GND   GND
K8   VCCPAUX   POWER
K9   VP_0   NC
K10   VREFN_0   NC
K11   GND   GND
K12   VCCINT   POWER
K13   GND   GND
K14   ESHUTDOWN_OUT_FPGA   LVCMOS33_S_12_HR
K15   GND   GND
K16   RELAY_3PH_FPGA   LVCMOS33_S_12_HR
K17   FAN_CTRL1_FPGA   LVCMOS33_S_12_HR
K18   FAN_EN1_FPGA   LVCMOS33_S_12_HR
K19   IO_L10P_T1_AD11P_35   NC
K20   VCCO_35   POWER
L1   DDR_addr[5]   SSTL15_S_PSDDR
L2   DDR_ck_p   SSTL15_F_PSDDR
L3   VCCO_DDR_502   POWER
L4   DDR_addr[6]   SSTL15_S_PSDDR
L5   DDR_ba[0]   SSTL15_S_PSDDR
L6   PROGRAM_B_0   LVCMOS18_F_12_HR
L7   VCCPINT   POWER
L8   GND   GND
L9   VREFP_0   NC
L10   VN_0   NC
L11   VCCAUX   POWER
L12   GND   GND
L13   VCCINT   POWER
L14   HV_ADC_SCLK_FPGA   LVCMOS33_S_12_HR
L15   HV_ADC_SDI_FPGA   LVCMOS33_S_12_HR
L16   FAN_HALL1_FPGA   LVCMOS33_S_8_HR
L17   FAN_PG1_FPGA   LVCMOS33_S_8_HR
L18   GND   GND
L19   IO_L9P_T1_DQS_AD3P_35   NC
L20   IO_L9N_T1_DQS_AD3N_35   NC
M1   GND   GND
M2   DDR_ck_n   SSTL15_F_PSDDR
M3   DDR_addr[2]   SSTL15_S_PSDDR
M4   DDR_addr[4]   SSTL15_S_PSDDR
M5   DDR_we_n   SSTL15_S_PSDDR
M6   CFGBVS_0   LVCMOS18_F_12_HR
M7   GND   GND
M8   VCCPAUX   POWER
M9   DXP_0   NC
M10   DXN_0   NC
M11   GND   GND
M12   VCCINT   POWER
M13   GND   GND
M14   HV_ADC_SDO_FPGA   LVCMOS33_S_8_HR
M15   HV_ADC_CS_FPGA   LVCMOS33_S_12_HR
M16   VCCO_35   POWER
M17   IO_L8P_T1_AD10P_35   NC
M18   IO_L8N_T1_AD10N_35   NC
M19   IO_L7P_T1_AD2P_35   NC
M20   IO_L7N_T1_AD2N_35   NC
N1   DDR_cs_n   SSTL15_S_PSDDR
N2   DDR_addr[0]   SSTL15_S_PSDDR
N3   DDR_cke   SSTL15_S_PSDDR
N4   GND   GND
N5   DDR_odt   SSTL15_S_PSDDR
N6   RSVDVCC3   NC
N7   VCCPINT   POWER
N8   GND   GND
N9   VCCAUX   POWER
N10   GND   GND
N11   VCCAUX   POWER
N12   GND   GND
N13   VCCINT   POWER
N14   GND   GND
N15   UART_RXD_PL   LVCMOS33_S_8_HR
N16   UART_TXD_PL   LVCMOS33_S_12_HR
N17   PG_PSU_9_FB   LVCMOS33_S_8_HR
N18   RS485_TXD_9   LVCMOS33_S_12_HR
N19   VCCO_34   POWER
N20   IO_L14P_T2_SRCC_34   NC
P1   DDR_dq[16]   SSTL15_DCI_F_PSDDR_MS
P2   VCCO_DDR_502   POWER
P3   DDR_dq[17]   SSTL15_DCI_F_PSDDR_MS
P4   DDR_ras_n   SSTL15_S_PSDDR
P5   DDR_cas_n   SSTL15_S_PSDDR
P6   PS_DDR_VREF1_502   NC
P7   GND   GND
P8   VCCPINT   POWER
P9   GND   GND
P10   VCCAUX   POWER
P11   GND   GND
P12   VCCINT   POWER
P13   GND   GND
P14   RS485_DE_4   LVCMOS33_S_12_HR
P15   PG_PSU_10_FB   LVCMOS33_S_8_HR
P16   EN_PSU_10_FB   LVCMOS33_S_12_HR
P17   GND   GND
P18   EN_PSU_9_FB   LVCMOS33_S_12_HR
P19   RS485_DE_9   LVCMOS33_S_12_HR
P20   IO_L14N_T2_SRCC_34   NC
R1   DDR_dq[19]   SSTL15_DCI_F_PSDDR_MS
R2   DDR_dqs_p[2]   SSTL15_DCI_F_PSDDR_MS
R3   DDR_dq[18]   SSTL15_DCI_F_PSDDR_MS
R4   DDR_ba[1]   SSTL15_S_PSDDR
R5   VCCO_DDR_502   POWER
R6   RSVDVCC2   NC
R7   VCCPINT   POWER
R8   GND   GND
R9   VCCAUX   POWER
R10   INIT_B_0   LVCMOS18_F_12_HR
R11   DONE_0   LVCMOS18_F_12_HR
R12   GND   GND
R13   VCCINT   POWER
R14   RS485_RXD_5   LVCMOS33_S_8_HR
R15   VCCO_34   POWER
R16   PG_PSU_5_FB   LVCMOS33_S_8_HR
R17   EN_PSU_5_FB   LVCMOS33_S_12_HR
R18   EN_PSU_6_FB   LVCMOS33_S_12_HR
R19   RS485_RXD_1   LVCMOS33_S_8_HR
R20   GND   GND
T1   DDR_dm[2]   SSTL15_DCI_F_PSDDR_MS
T2   DDR_dqs_n[2]   SSTL15_DCI_F_PSDDR_MS
T3   GND   GND
T4   DDR_dq[20]   SSTL15_DCI_F_PSDDR_MS
T5   IO_L19P_T3_13   NC
T6   RSVDVCC1   NC
T7   GND   GND
T8   VCCO_13   POWER
T9   I_SNS_ADC_SCLK_FPGA   LVCMOS33_S_12_HR
T10   RS485_DE_1   LVCMOS33_S_12_HR
T11   RS485_TXD_1   LVCMOS33_S_12_HR
T12   RS485_RXD_2   LVCMOS33_S_8_HR
T13   GND   GND
T14   RS485_RXD_4   LVCMOS33_S_8_HR
T15   RS485_TXD_4   LVCMOS33_S_12_HR
T16   RS485_DE_6   LVCMOS33_S_12_HR
T17   PG_PSU_6_FB   LVCMOS33_S_8_HR
T18   VCCO_34   POWER
T19   IO_25_34   NC
T20   PG_BUCK_FB   LVCMOS33_S_8_HR
U1   VCCO_DDR_502   POWER
U2   DDR_dq[22]   SSTL15_DCI_F_PSDDR_MS
U3   DDR_dq[23]   SSTL15_DCI_F_PSDDR_MS
U4   DDR_dq[21]   SSTL15_DCI_F_PSDDR_MS
U5   IO_L19N_T3_VREF_13   NC
U6   GND   GND
U7   IO_L11P_T1_SRCC_13   NC
U8   IO_L17N_T2_13   NC
U9   IO_L17P_T2_13   NC
U10   I_SNS_ADC_SDI_FPGA   LVCMOS33_S_12_HR
U11   VCCO_13   POWER
U12   RS485_TXD_2   LVCMOS33_S_12_HR
U13   RS485_DE_2   LVCMOS33_S_12_HR
U14   RS485_RXD_8   LVCMOS33_S_8_HR
U15   RS485_TXD_8   LVCMOS33_S_12_HR
U16   GND   GND
U17   RS485_RXD_7   LVCMOS33_S_8_HR
U18   RS485_DE_8   LVCMOS33_S_12_HR
U19   RS485_RXD_9   LVCMOS33_S_8_HR
U20   EN_PFC_FB   LVCMOS33_S_12_HR
V1   DDR_dq[24]   SSTL15_DCI_F_PSDDR_MS
V2   DDR_dq[30]   SSTL15_DCI_F_PSDDR_MS
V3   DDR_dq[31]   SSTL15_DCI_F_PSDDR_MS
V4   VCCO_DDR_502   POWER
V5   POWERON_FPGA   LVCMOS33_S_8_HR
V6   IO_L22P_T3_13   NC
V7   I_SNS_ADC_CS_FPGA   LVCMOS33_S_12_HR
V8   ZCR_SNS_ADC_SDI_FPGA   LVCMOS33_S_12_HR
V9   GND   GND
V10   IO_L21N_T3_DQS_13   NC
V11   IO_L21P_T3_DQS_13   NC
V12   RS485_TXD_3   LVCMOS33_S_12_HR
V13   RS485_RXD_3   LVCMOS33_S_8_HR
V14   VCCO_34   POWER
V15   RS485_TXD_7   LVCMOS33_S_12_HR
V16   PG_PSU_2_FB   LVCMOS33_S_8_HR
V17   PG_PSU_7_FB   LVCMOS33_S_8_HR
V18   EN_PSU_7_FB   LVCMOS33_S_12_HR
V19   GND   GND
V20   IO_L16P_T2_34   NC
W1   DDR_dq[26]   SSTL15_DCI_F_PSDDR_MS
W2   GND   GND
W3   DDR_dq[29]   SSTL15_DCI_F_PSDDR_MS
W4   DDR_dqs_n[3]   SSTL15_DCI_F_PSDDR_MS
W5   DDR_dqs_p[3]   SSTL15_DCI_F_PSDDR_MS
W6   IO_L22N_T3_13   NC
W7   VCCO_13   POWER
W8   ZCR_SNS_ADC_SDO_FPGA   LVCMOS33_S_8_HR
W9   IO_L16N_T2_13   NC
W10   IO_L16P_T2_13   NC
W11   IO_L18P_T2_13   NC
W12   GND   GND
W13   RS485_DE_3   LVCMOS33_S_12_HR
W14   RS485_RXD_6   LVCMOS33_S_8_HR
W15   RS485_DE_7   LVCMOS33_S_12_HR
W16   EN_PSU_2_FB   LVCMOS33_S_12_HR
W17   VCCO_34   POWER
W18   PG_PSU_8_FB   LVCMOS33_S_8_HR
W19   EN_PSU_8_FB   LVCMOS33_S_12_HR
W20   IO_L16N_T2_34   NC
Y1   DDR_dm[3]   SSTL15_DCI_F_PSDDR_MS
Y2   DDR_dq[28]   SSTL15_DCI_F_PSDDR_MS
Y3   DDR_dq[25]   SSTL15_DCI_F_PSDDR_MS
Y4   DDR_dq[27]   SSTL15_DCI_F_PSDDR_MS
Y5   GND   GND
Y6   IO_L13N_T2_MRCC_13   NC
Y7   I_SNS_ADC_SDO_FPGA   LVCMOS33_S_8_HR
Y8   ZCR_SNS_ADC_SCLK_FPGA   LVCMOS33_S_12_HR
Y9   ZCR_SNS_ADC_CS_FPGA   LVCMOS33_S_12_HR
Y10   VCCO_13   POWER
Y11   IO_L18N_T2_13   NC
Y12   IO_L20P_T3_13   NC
Y13   IO_L20N_T3_13   NC
Y14   RS485_TXD_6   LVCMOS33_S_12_HR
Y15   GND   GND
Y16   RS485_TXD_5   LVCMOS33_S_12_HR
Y17   RS485_DE_5   LVCMOS33_S_12_HR
Y18   PG_PSU_1_FB   LVCMOS33_S_8_HR
Y19   EN_PSU_1_FB   LVCMOS33_S_12_HR
Y20   VCCO_34   POWER
[Package Model]   xc7z020_clg400
[Diff Pin]   inv_pin   vdiff   tdelay_typ   tdelay_min   tdelay_max
C2   B2   100mv   0   0   0
| DDR_dqs_p[0]   DIFF_SSTL15_T_DCI_F_PSDDR_P SSTL15_DCI_F_PSDDR_IN50_I
G2   F2   100mv   0   0   0
| DDR_dqs_p[1]   DIFF_SSTL15_T_DCI_F_PSDDR_P SSTL15_DCI_F_PSDDR_IN50_I
L2   M2   100mv   0   0   0
| DDR_ck_p   DIFF_SSTL15_F_PSDDR_P SSTL15_F_PSDDR
R2   T2   100mv   0   0   0
| DDR_dqs_p[2]   DIFF_SSTL15_T_DCI_F_PSDDR_P SSTL15_DCI_F_PSDDR_IN50_I
W5   W4   100mv   0   0   0
| DDR_dqs_p[3]   DIFF_SSTL15_T_DCI_F_PSDDR_P SSTL15_DCI_F_PSDDR_IN50_I
[Model Selector]   SSTL15_DCI_F_PSDDR_MS
SSTL15_DCI_F_PSDDR_IN40_I   Input
SSTL15_DCI_F_PSDDR_IN50_I   Input
SSTL15_DCI_F_PSDDR_IN60_I   Input
SSTL15_DCI_F_PSDDR_O   Output
[Define Package Model]   xc7z020_clg400
[Manufacturer]   Xilinx Inc.
[OEM]   Xilinx
[Description]   400 ball organic wirebond
|[Number of Sections]   1
[Number of Pins]   291
[Pin Numbers]
|[Pin Name]  Net Number   Net Name   Net's All Pins
J9   | 1   VCCADC_0   J9
J11   | 2   VCCAUX   J11
   |L11
   |N9
   |N11
   |P10
   |R9
F11   | 3   VCCBATT_0   F11
G11   | 4   VCCBRAM   G11
   |H10
G13   | 5   VCCINT   G13
   |H12
   |J13
   |K12
   |L13
   |M12
   |N13
   |P12
   |R13
K6   | 6   VCCO_0   K6
T8   | 7   VCCO_13   T8
   |U11
   |W7
   |Y10
N19   | 8   VCCO_34   N19
   |R15
   |T18
   |V14
   |W17
   |Y20
C19   | 9   VCCO_35   C19
   |F18
   |H14
   |J17
   |K20
   |M16
A3   | 10   VCCO_DDR_502   A3
   |D2
   |E5
   |G1
   |H4
   |L3
   |P2
   |R5
   |U1
   |V4
B6   | 11   VCCO_MIO0_500   B6
   |D7
A13   | 12   VCCO_MIO1_501   A13
   |B16
   |D12
   |E15
F8   | 13   VCCPAUX   F8
   |G9
   |H8
   |K8
   |M8
G7   | 14   VCCPINT   G7
   |J7
   |L7
   |N7
   |P8
   |R7
G8   | 15   VCCPLL   G8
M6   | 16   CFGBVS_0   M6
R11   | 17   DONE_0   R11
M10   | 18   DXN_0   M10
M9   | 19   DXP_0   M9
R10   | 20   INIT_B_0   R10
R19   | 21   IO_0_34   R19
G14   | 22   IO_0_35   G14
T19   | 23   IO_25_34   T19
J15   | 24   IO_25_35   J15
T10   | 25   IO_L1N_T0_34   T10
B20   | 26   IO_L1N_T0_AD0N_35   B20
T11   | 27   IO_L1P_T0_34   T11
C20   | 28   IO_L1P_T0_AD0P_35   C20
U12   | 29   IO_L2N_T0_34   U12
A20   | 30   IO_L2N_T0_AD8N_35   A20
T12   | 31   IO_L2P_T0_34   T12
B19   | 32   IO_L2P_T0_AD8P_35   B19
V13   | 33   IO_L3N_T0_DQS_34   V13
D18   | 34   IO_L3N_T0_DQS_AD1N_35   D18
E17   | 35   IO_L3P_T0_DQS_AD1P_35   E17
U13   | 36   IO_L3P_T0_DQS_PUDC_B_34   U13
W13   | 37   IO_L4N_T0_34   W13
D20   | 38   IO_L4N_T0_35   D20
V12   | 39   IO_L4P_T0_34   V12
D19   | 40   IO_L4P_T0_35   D19
T15   | 41   IO_L5N_T0_34   T15
E19   | 42   IO_L5N_T0_AD9N_35   E19
T14   | 43   IO_L5P_T0_34   T14
E18   | 44   IO_L5P_T0_AD9P_35   E18
V5   | 45   IO_L6N_T0_VREF_13   V5
R14   | 46   IO_L6N_T0_VREF_34   R14
F17   | 47   IO_L6N_T0_VREF_35   F17
P14   | 48   IO_L6P_T0_34   P14
F16   | 49   IO_L6P_T0_35   F16
Y17   | 50   IO_L7N_T1_34   Y17
M20   | 51   IO_L7N_T1_AD2N_35   M20
Y16   | 52   IO_L7P_T1_34   Y16
M19   | 53   IO_L7P_T1_AD2P_35   M19
Y14   | 54   IO_L8N_T1_34   Y14
M18   | 55   IO_L8N_T1_AD10N_35   M18
W14   | 56   IO_L8P_T1_34   W14
M17   | 57   IO_L8P_T1_AD10P_35   M17
U17   | 58   IO_L9N_T1_DQS_34   U17
L20   | 59   IO_L9N_T1_DQS_AD3N_35   L20
T16   | 60   IO_L9P_T1_DQS_34   T16
L19   | 61   IO_L9P_T1_DQS_AD3P_35   L19
W15   | 62   IO_L10N_T1_34   W15
J19   | 63   IO_L10N_T1_AD11N_35   J19
V15   | 64   IO_L10P_T1_34   V15
K19   | 65   IO_L10P_T1_AD11P_35   K19
V7   | 66   IO_L11N_T1_SRCC_13   V7
U15   | 67   IO_L11N_T1_SRCC_34   U15
L17   | 68   IO_L11N_T1_SRCC_35   L17
U7   | 69   IO_L11P_T1_SRCC_13   U7
U14   | 70   IO_L11P_T1_SRCC_34   U14
L16   | 71   IO_L11P_T1_SRCC_35   L16
U10   | 72   IO_L12N_T1_MRCC_13   U10
U19   | 73   IO_L12N_T1_MRCC_34   U19
K18   | 74   IO_L12N_T1_MRCC_35   K18
T9   | 75   IO_L12P_T1_MRCC_13   T9
U18   | 76   IO_L12P_T1_MRCC_34   U18
K17   | 77   IO_L12P_T1_MRCC_35   K17
Y6   | 78   IO_L13N_T2_MRCC_13   Y6
P19   | 79   IO_L13N_T2_MRCC_34   P19
H17   | 80   IO_L13N_T2_MRCC_35   H17
Y7   | 81   IO_L13P_T2_MRCC_13   Y7
N18   | 82   IO_L13P_T2_MRCC_34   N18
H16   | 83   IO_L13P_T2_MRCC_35   H16
H18   | 84   IO_L14N_T2_AD4N_SRCC_35   H18
Y8   | 85   IO_L14N_T2_SRCC_13   Y8
P20   | 86   IO_L14N_T2_SRCC_34   P20
J18   | 87   IO_L14P_T2_AD4P_SRCC_35   J18
Y9   | 88   IO_L14P_T2_SRCC_13   Y9
N20   | 89   IO_L14P_T2_SRCC_34   N20
W8   | 90   IO_L15N_T2_DQS_13   W8
U20   | 91   IO_L15N_T2_DQS_34   U20
F20   | 92   IO_L15N_T2_DQS_AD12N_35   F20
V8   | 93   IO_L15P_T2_DQS_13   V8
T20   | 94   IO_L15P_T2_DQS_34   T20
F19   | 95   IO_L15P_T2_DQS_AD12P_35   F19
W9   | 96   IO_L16N_T2_13   W9
W20   | 97   IO_L16N_T2_34   W20
G18   | 98   IO_L16N_T2_35   G18
W10   | 99   IO_L16P_T2_13   W10
V20   | 100   IO_L16P_T2_34   V20
G17   | 101   IO_L16P_T2_35   G17
U8   | 102   IO_L17N_T2_13   U8
Y19   | 103   IO_L17N_T2_34   Y19
H20   | 104   IO_L17N_T2_AD5N_35   H20
U9   | 105   IO_L17P_T2_13   U9
Y18   | 106   IO_L17P_T2_34   Y18
J20   | 107   IO_L17P_T2_AD5P_35   J20
Y11   | 108   IO_L18N_T2_13   Y11
W16   | 109   IO_L18N_T2_34   W16
G20   | 110   IO_L18N_T2_AD13N_35   G20
W11   | 111   IO_L18P_T2_13   W11
V16   | 112   IO_L18P_T2_34   V16
G19   | 113   IO_L18P_T2_AD13P_35   G19
U5   | 114   IO_L19N_T3_VREF_13   U5
R17   | 115   IO_L19N_T3_VREF_34   R17
G15   | 116   IO_L19N_T3_VREF_35   G15
T5   | 117   IO_L19P_T3_13   T5
R16   | 118   IO_L19P_T3_34   R16
H15   | 119   IO_L19P_T3_35   H15
Y13   | 120   IO_L20N_T3_13   Y13
R18   | 121   IO_L20N_T3_34   R18
J14   | 122   IO_L20N_T3_AD6N_35   J14
Y12   | 123   IO_L20P_T3_13   Y12
T17   | 124   IO_L20P_T3_34   T17
K14   | 125   IO_L20P_T3_AD6P_35   K14
V10   | 126   IO_L21N_T3_DQS_13   V10
V18   | 127   IO_L21N_T3_DQS_34   V18
N16   | 128   IO_L21N_T3_DQS_AD14N_35   N16
V11   | 129   IO_L21P_T3_DQS_13   V11
V17   | 130   IO_L21P_T3_DQS_34   V17
N15   | 131   IO_L21P_T3_DQS_AD14P_35   N15
W6   | 132   IO_L22N_T3_13   W6
W19   | 133   IO_L22N_T3_34   W19
L15   | 134   IO_L22N_T3_AD7N_35   L15
V6   | 135   IO_L22P_T3_13   V6
W18   | 136   IO_L22P_T3_34   W18
L14   | 137   IO_L22P_T3_AD7P_35   L14
P18   | 138   IO_L23N_T3_34   P18
M15   | 139   IO_L23N_T3_35   M15
N17   | 140   IO_L23P_T3_34   N17
M14   | 141   IO_L23P_T3_35   M14
P16   | 142   IO_L24N_T3_34   P16
J16   | 143   IO_L24N_T3_AD15N_35   J16
P15   | 144   IO_L24P_T3_34   P15
K16   | 145   IO_L24P_T3_AD15P_35   K16
L6   | 146   PROGRAM_B_0   L6
E7   | 147   PS_CLK_500   E7
N2   | 148   PS_DDR_A0_502   N2
K2   | 149   PS_DDR_A1_502   K2
M3   | 150   PS_DDR_A2_502   M3
K3   | 151   PS_DDR_A3_502   K3
M4   | 152   PS_DDR_A4_502   M4
L1   | 153   PS_DDR_A5_502   L1
L4   | 154   PS_DDR_A6_502   L4
K4   | 155   PS_DDR_A7_502   K4
K1   | 156   PS_DDR_A8_502   K1
J4   | 157   PS_DDR_A9_502   J4
F5   | 158   PS_DDR_A10_502   F5
G4   | 159   PS_DDR_A11_502   G4
E4   | 160   PS_DDR_A12_502   E4
D4   | 161   PS_DDR_A13_502   D4
F4   | 162   PS_DDR_A14_502   F4
L5   | 163   PS_DDR_BA0_502   L5
R4   | 164   PS_DDR_BA1_502   R4
J5   | 165   PS_DDR_BA2_502   J5
P5   | 166   PS_DDR_CAS_B_502   P5
N3   | 167   PS_DDR_CKE_502   N3
M2   | 168   PS_DDR_CKN_502   M2
L2   | 169   PS_DDR_CKP_502   L2
N1   | 170   PS_DDR_CS_B_502   N1
A1   | 171   PS_DDR_DM0_502   A1
F1   | 172   PS_DDR_DM1_502   F1
T1   | 173   PS_DDR_DM2_502   T1
Y1   | 174   PS_DDR_DM3_502   Y1
C3   | 175   PS_DDR_DQ0_502   C3
B3   | 176   PS_DDR_DQ1_502   B3
A2   | 177   PS_DDR_DQ2_502   A2
A4   | 178   PS_DDR_DQ3_502   A4
D3   | 179   PS_DDR_DQ4_502   D3
D1   | 180   PS_DDR_DQ5_502   D1
C1   | 181   PS_DDR_DQ6_502   C1
E1   | 182   PS_DDR_DQ7_502   E1
E2   | 183   PS_DDR_DQ8_502   E2
E3   | 184   PS_DDR_DQ9_502   E3
G3   | 185   PS_DDR_DQ10_502   G3
H3   | 186   PS_DDR_DQ11_502   H3
J3   | 187   PS_DDR_DQ12_502   J3
H2   | 188   PS_DDR_DQ13_502   H2
H1   | 189   PS_DDR_DQ14_502   H1
J1   | 190   PS_DDR_DQ15_502   J1
P1   | 191   PS_DDR_DQ16_502   P1
P3   | 192   PS_DDR_DQ17_502   P3
R3   | 193   PS_DDR_DQ18_502   R3
R1   | 194   PS_DDR_DQ19_502   R1
T4   | 195   PS_DDR_DQ20_502   T4
U4   | 196   PS_DDR_DQ21_502   U4
U2   | 197   PS_DDR_DQ22_502   U2
U3   | 198   PS_DDR_DQ23_502   U3
V1   | 199   PS_DDR_DQ24_502   V1
Y3   | 200   PS_DDR_DQ25_502   Y3
W1   | 201   PS_DDR_DQ26_502   W1
Y4   | 202   PS_DDR_DQ27_502   Y4
Y2   | 203   PS_DDR_DQ28_502   Y2
W3   | 204   PS_DDR_DQ29_502   W3
V2   | 205   PS_DDR_DQ30_502   V2
V3   | 206   PS_DDR_DQ31_502   V3
B2   | 207   PS_DDR_DQS_N0_502   B2
F2   | 208   PS_DDR_DQS_N1_502   F2
T2   | 209   PS_DDR_DQS_N2_502   T2
W4   | 210   PS_DDR_DQS_N3_502   W4
C2   | 211   PS_DDR_DQS_P0_502   C2
G2   | 212   PS_DDR_DQS_P1_502   G2
R2   | 213   PS_DDR_DQS_P2_502   R2
W5   | 214   PS_DDR_DQS_P3_502   W5
B4   | 215   PS_DDR_DRST_B_502   B4
N5   | 216   PS_DDR_ODT_502   N5
P4   | 217   PS_DDR_RAS_B_502   P4
H6   | 218   PS_DDR_VREF0_502   H6
P6   | 219   PS_DDR_VREF1_502   P6
G5   | 220   PS_DDR_VRN_502   G5
H5   | 221   PS_DDR_VRP_502   H5
M5   | 222   PS_DDR_WE_B_502   M5
E6   | 223   PS_MIO0_500   E6
A7   | 224   PS_MIO1_500   A7
B8   | 225   PS_MIO2_500   B8
D6   | 226   PS_MIO3_500   D6
B7   | 227   PS_MIO4_500   B7
A6   | 228   PS_MIO5_500   A6
A5   | 229   PS_MIO6_500   A5
D8   | 230   PS_MIO7_500   D8
D5   | 231   PS_MIO8_500   D5
B5   | 232   PS_MIO9_500   B5
E9   | 233   PS_MIO10_500   E9
C6   | 234   PS_MIO11_500   C6
D9   | 235   PS_MIO12_500   D9
E8   | 236   PS_MIO13_500   E8
C5   | 237   PS_MIO14_500   C5
C8   | 238   PS_MIO15_500   C8
A19   | 239   PS_MIO16_501   A19
E14   | 240   PS_MIO17_501   E14
B18   | 241   PS_MIO18_501   B18
D10   | 242   PS_MIO19_501   D10
A17   | 243   PS_MIO20_501   A17
F14   | 244   PS_MIO21_501   F14
B17   | 245   PS_MIO22_501   B17
D11   | 246   PS_MIO23_501   D11
A16   | 247   PS_MIO24_501   A16
F15   | 248   PS_MIO25_501   F15
A15   | 249   PS_MIO26_501   A15
D13   | 250   PS_MIO27_501   D13
C16   | 251   PS_MIO28_501   C16
C13   | 252   PS_MIO29_501   C13
C15   | 253   PS_MIO30_501   C15
E16   | 254   PS_MIO31_501   E16
A14   | 255   PS_MIO32_501   A14
D15   | 256   PS_MIO33_501   D15
A12   | 257   PS_MIO34_501   A12
F12   | 258   PS_MIO35_501   F12
A11   | 259   PS_MIO36_501   A11
A10   | 260   PS_MIO37_501   A10
E13   | 261   PS_MIO38_501   E13
C18   | 262   PS_MIO39_501   C18
D14   | 263   PS_MIO40_501   D14
C17   | 264   PS_MIO41_501   C17
E12   | 265   PS_MIO42_501   E12
A9   | 266   PS_MIO43_501   A9
F13   | 267   PS_MIO44_501   F13
B15   | 268   PS_MIO45_501   B15
D16   | 269   PS_MIO46_501   D16
B14   | 270   PS_MIO47_501   B14
B12   | 271   PS_MIO48_501   B12
C12   | 272   PS_MIO49_501   C12
B13   | 273   PS_MIO50_501   B13
B9   | 274   PS_MIO51_501   B9
C10   | 275   PS_MIO52_501   C10
C11   | 276   PS_MIO53_501   C11
E11   | 277   PS_MIO_VREF_501   E11
C7   | 278   PS_POR_B_500   C7
B10   | 279   PS_SRST_B_501   B10
R6   | 280   RSVDGND2_0   R6
F10   | 281   RSVDGND4_0   F10
T6   | 282   RSVDVCC1_0   T6
N6   | 283   RSVDVCC3_0   N6
F9   | 284   TCK_0   F9
G6   | 285   TDI_0   G6
F6   | 286   TDO_0   F6
J6   | 287   TMS_0   J6
L10   | 288   VN_0   L10
K9   | 289   VP_0   K9
K10   | 290   VREFN_0   K10
L9   | 291   VREFP_0   L9
[Model Data]
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[End Model Data]
[End Package Model]
| Models and submodels in the file (11): LVCMOS18_F_12_HR (I/O), LVCMOS18_S_8_PSMIO (I/O), LVCMOS33_S_12_HR (I/O), LVCMOS33_S_8_HR (I/O), LVCMOS33_S_8_PSMIO (I/O), SSTL15_DCI_F_PSDDR_IN40_I (Input), SSTL15_DCI_F_PSDDR_IN50_I (Input), SSTL15_DCI_F_PSDDR_IN60_I (Input), SSTL15_DCI_F_PSDDR_O (Output), SSTL15_F_PSDDR (I/O), SSTL15_S_PSDDR (I/O)
